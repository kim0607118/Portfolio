# Ansys Electronics Desktop project, version 2022.2
materials:
  vacuum: permittivity=1
  Taconic TLY (tm): permittivity=2.2 dielectric_loss_tangent=0.0009

design HFSSDesign1 (HFSS, DrivenTerminal, model units mm)
variables:
  substrate = 40mm
  h = 1.52mm
  Lp = 7.5mm
  Wp = 10mm
  x0 = 2.6mm
  y0 = 2.8mm
  w50 = 1.76mm
  L1 = 2mm
  QW = 15mm
geometry:
  Substate [Taconic TLY (tm)] = box(corner=(-substrate/2, -substrate/2, 0mm), size=(substrate, substrate, -h))
  Ground_Plane = rectangle(corner=(-substrate/2, -substrate/2, -h), x_size=substrate, y_size=substrate)
  Patch = rectangle(corner=(-Lp/2, -Wp/2, 0mm), x_size=Lp, y_size=Wp)
  Gap = rectangle(corner=(Lp/2-x0, -y0/2, 0mm), x_size=x0, y_size=y0)
  Patch.subtract(Gap)
  Feed_Line = rectangle(corner=(Lp/2-x0, -w50/2.0, 0mm), x_size=x0+L1, y_size=w50)
  Patch.unite(Feed_Line)
  Source = object_from(Patch.edge(2 of 4))
  Source.sweep_along_vector((0mm, 0mm, -h))
  Air [vacuum] = box(corner=(-substrate/2, -substrate/2, 0mm), size=(substrate, substrate, QW))
boundaries and excitations:
  PerfE_Groumd: Perfect E Objects=Ground_Plane
  PerfE_Patch: Perfect E Objects=Patch
  1: Terminal port=P1 Edges=Patch.edge(2 of 4) TerminalResistance=50ohm
  P1: Lumped Port Faces=Source.face Impedance=50ohm
  reference conductors: Ground_Plane
source amplitudes:
  P1:1: 1V 0deg
